switch
.include TSMC_180nm.txt

.param LAMBDA=0.09u
.param L_n=2*LAMBDA
.param width_N=20*LAMBDA
.param SUPPLY=1.8

M1 in ctrl out nb CMOSP L={L_n} W={width_N}
+ AS={5*width_N*LAMBDA}
+ PS={10*LAMBDA+2*width_N}
+ AD={5*width_N*LAMBDA}
+ PD={10*LAMBDA+2*width_N}

Vb nb gnd {SUPPLY}

C1 out gnd 100p IC=1.8

Vin in gnd 0
Vctrl ctrl gnd 0

.tran 100p 10u uic

.control
run
print v(out)[0]
plot v(out)
.endc

.end
